* circuit under test (no sources / analysis).  Fig 8.3 envelope (diode) AM detector. 1 MHz carrier, 1 kHz tone, m=0.5, 1N4148, Rl=10k, C=10 nF (tau=100 us).
.model D1N4148 D(Is=2.5n Rs=0.6 N=1.7 Cjo=4p Bv=100)
Rs am a 50
D1 a o D1N4148
Cl o 0 10n
Rl o 0 10k
Cc o aud 10u
Rla aud 0 100k
