* testbench for circuit.cir: Fig 3.51/3.52 JFET common-source amplifier with self bias and source bypass (2N5486-class model, values assumed).
.include circuit.cir
Vin in 0 AC 1
.control
op
print v(d) v(s)
ac dec 20 10 10Meg
meas ac gain find vdb(out) at=10k
echo "JFET CS: midband gain = $&gain dB"
.endc
.end
