* Fig 3.51/3.52 JFET common-source amplifier with self bias and source bypass (2N5486-class model, values assumed).
.model J2N5486 NJF(Vto=-2.2 Beta=1.5m Lambda=0.02 Cgs=4p Cgd=2p)
Vdd vdd 0 12
Vin in 0 AC 1
Cin in g 100n
Rg g 0 1Meg
Rs s 0 1.5k
Cs s 0 100u
Rd vdd d 2.2k
J1 d g s J2N5486
Cout d out 100n
Rl out 0 100k
.control
op
print v(d) v(s)
ac dec 20 10 10Meg
meas ac gain find vdb(out) at=10k
echo "JFET CS: midband gain = $&gain dB"
.endc
.end
