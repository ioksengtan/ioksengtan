* circuit under test (no sources / analysis).  Fig 7.30 buck converter, 12 V -> D=0.5 -> ~6 V. 100 kHz, L=100 uH, C=100 uF, load 6 ohm (1 A). Ideal switch + 1N5819 style diode.
.model SW1 SW(Ron=0.05 Roff=1Meg Vt=0.5 Vh=0)
.model DSCH D(Is=1u Rs=0.05 N=1.05 Cjo=100p Bv=40)
S1 in sw g 0 SW1
D1 0 sw DSCH
L1 sw o 100u
Cout o 0 100u
Rl o 0 6
