* Fig 3.61 inverting and non-inverting op-amp stages, 741-class model (linear: gain 200k, GBW 1 MHz, no output limiting)
.subckt opa p n out
Eg  1 0 p n 200k
Rp  1 2 1k
Cp  2 0 {1/(2*3.14159*1k*5)}
Eo  3 0 2 0 1
Ro  3 out 75
.ends
* Gain-of-10 non-inverting
V1 in 0 AC 1 SIN(0 0.1 1k)
Xa in fb o1 opa
Rf1 o1 fb 9k
Rg1 fb 0 1k
* Gain of -10 inverting
Xb 0 fb2 o2 opa
Rin2 in fb2 1k
Rf2 o2 fb2 10k
.control
ac dec 20 10 1Meg
meas ac g_ni find vdb(o1) at=1k
meas ac g_inv find vdb(o2) at=1k
meas ac bw_ni when vdb(o1)=17 cross=last
echo "NI gain=$&g_ni dB (target 20)  INV gain=$&g_inv dB (target 20)  NI -3dB BW=$&bw_ni Hz"
.endc
.end
