* testbench for circuit.cir: Fig 3.61 inverting and non-inverting op-amp stages, 741-class model (linear: gain 200k, GBW 1 MHz, no output limiting)
.include circuit.cir
V1 in 0 AC 1 SIN(0 0.1 1k)
.control
ac dec 20 10 1Meg
meas ac g_ni find vdb(o1) at=1k
meas ac g_inv find vdb(o2) at=1k
meas ac bw_ni when vdb(o1)=17 cross=last
echo "NI gain=$&g_ni dB (target 20)  INV gain=$&g_inv dB (target 20)  NI -3dB BW=$&bw_ni Hz"
.endc
.end
