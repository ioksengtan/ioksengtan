* circuit under test (no sources / analysis).  Fig 3.28A photodiode transimpedance amplifier. Photodiode modelled as current source + 20 pF; 741-class op amp (GBW 1 MHz).
.subckt opa p n out
Eg 1 0 p n 200k
Rp 1 2 1k
Cp 2 0 {1/(2*3.14159*1k*5)}
Eo 3 0 2 0 1
Ro 3 out 75
.ends
.param Rf=1Meg
Rf out n {Rf}
Cf out n 2p
Xa 0 n out opa
