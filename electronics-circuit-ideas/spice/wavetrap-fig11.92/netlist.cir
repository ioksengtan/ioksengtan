* Fig 11.92 broadcast-station wave trap: series LC shunt across the antenna input.
* L1 = 80 turns on ferrite rod (inductance not given in the caption -> ASSUMED 200 uH, Q=80), C1 = 300 pF polyvaricon (assumed 30-300 pF range).
* Test: 50 ohm source/load, sweep at 3 trap settings, reads the notch frequency.
.param Cv=300p
Vin in 0 AC 1
Rs in a 50
RL a 0 50
L1 a b0 200u
Rl1 b0 b 2.5
C1 b 0 {Cv}
.ac dec 400 0.3Meg 3Meg
.control
foreach c 300p 100p 40p
  alter C1 = $c
  run
  meas ac fnotch when vdb(a)=-15 cross=1
  meas ac a_1p0 find vdb(a) at=1.0Meg
  echo "C1=$c  f(notch)=$&fnotch  atten@1MHz=$&a_1p0 dB"
end
.endc
.end
