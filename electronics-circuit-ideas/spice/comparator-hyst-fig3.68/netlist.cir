* Fig 3.68 inverting Schmitt trigger (comparator with hysteresis): +-5 V output, R1=10k to ground, R2=100k from output. Thresholds = +-5*R1/(R1+R2) = +-0.4545 V. Thresholds from the positive-feedback divider: Vth = Vout*R1/(R1+R2).
.param R1=10k R2=100k
Vin in 0 PWL(0 -2 1m 2 2m -2)
Bcmp out 0 V = 5*tanh(2000*(v(fb)-v(in)))
Rfb out fb {R2}
Rg fb 0 {R1}
Rl out 0 100k
.tran 5u 2m
.control
run
let vo=v(out)
let vi=v(in)
let n=length(vo)
let up=0
let dn=0
let i=1
while i<n
 if vo[i]>0 & vo[i-1]<0
  let up=vi[i]
 end
 if vo[i]<0 & vo[i-1]>0
  let dn=vi[i]
 end
 let i=i+1
end
echo "output rises when input falls to $&up V ; output falls when input rises to $&dn V (theory -0.4545 / +0.4545 V)"

.endc
.end
