* testbench for circuit.cir: Fig 5.58 style Pi network, 50 ohm -> 200 ohm at 7.1 MHz, Q (input side) = 4.
.include circuit.cir
Vin in 0 AC 1
Rs in a 50
RL b 0 200
.ac lin 200 1Meg 20Meg
.control
run
let pload = mag(v(b))*mag(v(b))/200
let pavail = 1/(4*50)
let loss = -10*log10(pload/pavail)
meas ac loss7p1 find loss at=7.1Meg
meas ac lossmin min loss
echo "mismatch loss at 7.1 MHz = $&loss7p1 dB (min over sweep $&lossmin dB)"
.endc
.end
