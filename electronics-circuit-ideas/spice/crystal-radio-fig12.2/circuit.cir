* circuit under test.  ARRL Handbook 2011, Fig 12.2  Crystal set with a semiconductor diode detector.
* Values read from the figure: secondary 230 uH (105 turns) tuned by a 38-365 pF variable (110 pF here), antenna winding 30 turns (230u*(30/105)^2 = 18.8 uH),
* 1N34 germanium diode, 20 kohm + 0.01 uF audio load (2000 ohm headphone modelled as the 20 k load). Coupling K = 0.5 and the diode parameters are my choices.
Lp ant 0 18.8u
Ls t 0 230u
K1 Lp Ls 0.5
Ct t 0 110p
D1 t out D1N34
Rl out 0 20k
Cl out 0 10n
.model D1N34 D(Is=0.2u Rs=20 N=1.3 Cjo=1p Bv=60)
